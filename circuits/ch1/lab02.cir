D1 in out WP710A10SRD
R1 out N001 {R}
V1 in N001 {V}
.title Lab 02
.MODEL WP710A10SRD D(IS=2.45E-18 N=1.65 RS=4.5 BV=5 IBV=10U CJO=15P TT=20N EG=1.92 XTI=3)
.tran 50u 50m
.end
