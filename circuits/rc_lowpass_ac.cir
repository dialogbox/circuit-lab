* RC low-pass filter - AC sweep
$PARAMS$
V1 in 0 AC 1
R1 in out {R}
C1 out 0 {C}
.ac dec 50 1 10Meg
.end
