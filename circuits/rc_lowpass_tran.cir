* RC low-pass filter - transient (square wave input)
$PARAMS$
V1 in 0 PULSE(0 5 0 1n 1n {5*R*C} {10*R*C})
R1 in out {R}
C1 out 0 {C}
.tran {R*C/100} {20*R*C} 0 {R*C/100}
.end
